** sch_path: /home/jorge/VLSI-Projects/analog/tim-edwards-ws/inverter/xschem/inverter.sch
.subckt inverter Vdd in out gnd
*.PININFO in:I out:O gnd:B Vdd:B
XM1 out in gnd gnd sky130_fd_pr__nfet_01v8 L=0.18 W=4.5 nf=3
XM2 out in Vdd VDD sky130_fd_pr__pfet_01v8 L=0.18 W=3 nf=3
.ends
